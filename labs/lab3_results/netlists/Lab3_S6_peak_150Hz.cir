* Lab3 6.3 peak rectifier @ 150Hz
.lib "C:/Users/lance/tcl-mcp-server/lab3_results/1N4007.lib"
VIN VIN 0 SIN(0 3 150 0 0 0)
D1 VIN OUT 1N4007
C1 OUT 0 47u IC=0
R1 OUT 0 150
.TRAN 6.66666666666667E-06 0.0133333333333333 0 6.66666666666667E-06 UIC
.PRINT TRAN V([VIN]) V([OUT])
.PROBE/CSDF V([VIN]) V([OUT])
.END
